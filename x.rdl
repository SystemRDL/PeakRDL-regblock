
addrmap top {
    reg {
        field {
            hw=w; sw=rw; precedence=sw;
        } y = 0;

        field {
            hw=na; sw=rw;
        } x = 1;

        y->we;
        y->hwset;
    } whee;
};
