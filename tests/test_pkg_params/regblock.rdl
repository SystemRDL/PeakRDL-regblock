addrmap top #(
    longint N_REGS = 1,
    longint REGWIDTH = 32,
    string NAME = "abcd"
) {
    reg reg_t {
        regwidth = REGWIDTH;
        field {sw=rw; hw=r;} f[REGWIDTH] = 1;
    };
    reg_t regs[N_REGS];
};
