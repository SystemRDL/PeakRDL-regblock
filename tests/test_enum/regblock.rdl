addrmap top {
    enum my_enum {
        val_1 = 3 {name = "Value 1";};
        val_2 = 4 {desc = "Second value";};
    };
    reg {
        field {
            encode = my_enum;
            sw=rw; hw=na;
        } f[2:0] = my_enum::val_2;
    } r0;
};
