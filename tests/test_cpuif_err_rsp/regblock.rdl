addrmap top {
    default regwidth = 32;
    default sw=rw;
    default hw=na;

    reg {
        field {
            sw=rw; hw=na; // Storage element
        } f[31:0] = 40;
    } r_rw;

    reg {
        field {
            sw=r; hw=na; // Wire/Bus - constant value
        } f[31:0] = 80;
    } r_r;

    reg {
        field {
            sw=w; hw=r; // Storage element
        } f[31:0] = 100;
    } r_w;
};
