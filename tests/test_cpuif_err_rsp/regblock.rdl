addrmap top {
    default regwidth = 32;
    default sw=rw;
    default hw=na;

    // Internal registers
    reg {
        field {
            sw=rw; hw=na; // Storage element
        } f[31:0] = 40;
    } r_rw;

    reg {
        field {
            sw=r; hw=na; // Wire/Bus - constant value
        } f[31:0] = 80;
    } r_ro;

    reg {
        field {
            sw=w; hw=r; // Storage element
        } f[31:0] = 100;
    } r_wo;

    // Combined read-only and write-only register
    reg {
        default sw = w;
        default hw = r;
        field {} wvalue[32] = 0;
    } writeonly @ 0x1C;
    reg {
        default sw = r;
        default hw = na;
        field {} rvalue[32] = 200;
    } readonly @ 0x1C;

    // External memories
    external mem {
        memwidth = 32;
        mementries = 2;
    } mem_rw @ 0x20;

    external mem {
        memwidth = 32;
        mementries = 2;
        sw=r;
    } mem_ro @ 0x28;

    external mem {
        memwidth = 32;
        mementries = 2;
        sw=w;
    } mem_wo @ 0x30;

    // External block
    external regfile {
      // Placeholder registers
      reg {
          field {
              sw=rw; hw=na;
          } f[31:0] = 40;
      } r_rw;

      reg {
          field {
              sw=r; hw=na;
          } f[31:0] = 80;
      } r_ro;

      reg {
          field {
              sw=w; hw=r;
          } f[31:0] = 100;
      } r_wo;
    } external_rf @ 0x40;

    // Broadcast regfile test
    // Define a regfile type with different access types
    regfile broadcast_target_t {
        reg {
            field {
                sw=rw; hw=r;
                reset=0;
            } f[31:0];
        } r_rw @ 0x00;

        reg {
            field {
                sw=r; hw=na;
                reset=0;
            } f[31:0];
        } r_ro @ 0x04;

        reg {
            field {
                sw=w; hw=r;
                reset=0;
            } f[31:0];
        } r_wo @ 0x08;
    };

    // Target regfiles
    broadcast_target_t bc_target_a @ 0x50;
    broadcast_target_t bc_target_b @ 0x60;
    broadcast_target_t bc_target_c @ 0x70;

    // Broadcaster regfile
    broadcast_target_t bc_all @ 0x80;
    bc_all -> broadcast = '{ bc_target_a, bc_target_b, bc_target_c };
};
