addrmap top {
    reg {
        field {
            sw = rw; hw = r;
            intwidth = 4;
            counter;
        } fixedpoint_counter[8] = 0;
    } r1;
};
