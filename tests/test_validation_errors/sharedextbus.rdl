addrmap top {
    sharedextbus;

    reg {
        field {}f;
    } x;
};
